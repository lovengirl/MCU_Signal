TI_MCU stimulus smoke-test circuit
.INC "mcu_sources.lib"
XMCU TX_ADDR0 TX_ADDR1 TX_ADDR2 TX_ADDR3 TX_ADDR4 RX_ADDR0 RX_ADDR1 RX_ADDR2 RX_ADDR3 RX_ADDR4 TX_EN RX_EN LIGHT_SET 0 TI_MCU_STIM
RLOAD_TX_ADDR0 TX_ADDR0 0 1G
CLOAD_TX_ADDR0 TX_ADDR0 0 5p
RLOAD_TX_ADDR1 TX_ADDR1 0 1G
CLOAD_TX_ADDR1 TX_ADDR1 0 5p
RLOAD_TX_ADDR2 TX_ADDR2 0 1G
CLOAD_TX_ADDR2 TX_ADDR2 0 5p
RLOAD_TX_ADDR3 TX_ADDR3 0 1G
CLOAD_TX_ADDR3 TX_ADDR3 0 5p
RLOAD_TX_ADDR4 TX_ADDR4 0 1G
CLOAD_TX_ADDR4 TX_ADDR4 0 5p
RLOAD_RX_ADDR0 RX_ADDR0 0 1G
CLOAD_RX_ADDR0 RX_ADDR0 0 5p
RLOAD_RX_ADDR1 RX_ADDR1 0 1G
CLOAD_RX_ADDR1 RX_ADDR1 0 5p
RLOAD_RX_ADDR2 RX_ADDR2 0 1G
CLOAD_RX_ADDR2 RX_ADDR2 0 5p
RLOAD_RX_ADDR3 RX_ADDR3 0 1G
CLOAD_RX_ADDR3 RX_ADDR3 0 5p
RLOAD_RX_ADDR4 RX_ADDR4 0 1G
CLOAD_RX_ADDR4 RX_ADDR4 0 5p
RLOAD_TX_EN TX_EN 0 1G
CLOAD_TX_EN TX_EN 0 5p
RLOAD_RX_EN RX_EN 0 1G
CLOAD_RX_EN RX_EN 0 5p
RLOAD_LIGHT_SET LIGHT_SET 0 1G
CLOAD_LIGHT_SET LIGHT_SET 0 5p
* Placeholder loads only; replace with the actual product circuit.
.TRAN 1u 0.0038222 0 1u
.PROBE
.END
